# Ansys Electronics Desktop project, version 2025.2
materials:
  vacuum: permittivity=1
  pec: conductivity=1e+30
  PMLGroup1_Z_1: permittivity{anisotropic component1=1.1 component2=1.1 component3=0.45454545} permeability{anisotropic component1=1.1 component2=1.1 component3=0.45454545} dielectric_loss_tangent{anisotropic component1=1 component2=1 component3=-1} magnetic_loss_tangent{anisotropic component1=1 component2=1 component3=-1}
  PMLGroup1_XZ_1: permittivity{anisotropic component1=1 component2=0.01 component3=1} permeability{anisotropic component1=1 component2=0.01 component3=1} dielectric_loss_tangent{anisotropic component1=0 component2=242 component3=0} magnetic_loss_tangent{anisotropic component1=0 component2=242 component3=0}
  PMLGroup1_YZ_1: permittivity{anisotropic component1=0.01 component2=1 component3=1} permeability{anisotropic component1=0.01 component2=1 component3=1} dielectric_loss_tangent{anisotropic component1=242 component2=0 component3=0} magnetic_loss_tangent{anisotropic component1=242 component2=0 component3=0}
  PMLGroup1_XYZ_1: permittivity{anisotropic component1=1.1 component2=1.1 component3=1.1} permeability{anisotropic component1=1.1 component2=1.1 component3=1.1} dielectric_loss_tangent{anisotropic component1=1 component2=1 component3=1} magnetic_loss_tangent{anisotropic component1=1 component2=1 component3=1}

design OpenEndedWaveguide (HFSS, HFSS Modal Network, model units mm)
geometry:
  FeedXMinus = polyline(x=-10mm, yz in mm: (-5, -100) (5, -100) (5, -60) (-5, -60) (-5, -100), closed, covered)
  FeedXPlus = polyline(x=10mm, yz in mm: (-5, -100) (5, -100) (5, -60) (-5, -60) (-5, -100), closed, covered)
  FeedYMinus = polyline(y=-5mm, xz in mm: (-10, -100) (10, -100) (10, -60) (-10, -60) (-10, -100), closed, covered)
  FeedYPlus = polyline(y=5mm, xz in mm: (-10, -100) (10, -100) (10, -60) (-10, -60) (-10, -100), closed, covered)
  HornXMinus = polyline(xyz in mm: (-10, -5, -60) (-30, -10, 0) (-30, 10, 0) (-10, 5, -60) (-10, -5, -60), closed, covered)
  HornXPlus = polyline(xyz in mm: (10, -5, -60) (30, -10, 0) (30, 10, 0) (10, 5, -60) (10, -5, -60), closed, covered)
  HornYMinus = polyline(xyz in mm: (-10, -5, -60) (10, -5, -60) (30, -10, 0) (-30, -10, 0) (-10, -5, -60), closed, covered)
  HornYPlus = polyline(xyz in mm: (-10, 5, -60) (10, 5, -60) (30, 10, 0) (-30, 10, 0) (-10, 5, -60), closed, covered)
  WavePortSheet = rectangle(corner=(-10mm, -5mm, -100mm), x_size=20mm, y_size=10mm)
  WavePortPecBacking [pec] = box(corner=(-10mm, -5mm, -101mm), size=(20mm, 10mm, 1mm))
  RadiatingSurface [vacuum] = region(absolute_offset=2.5mm on all sides)
  coordinate_system FaceCS1 = face of RadiatingSurface: Origin=(32.5, -12.5, 2.5) FaceID=RadiatingSurface.face(+z) AxisPosn=(32.5, 12.5, 2.5) WhichAxis=X ZRotationAngle=0deg XOffset=0mm YOffset=0mm FaceNormal(0, 0, 1)
  PML_RadiatingSurface_1 [PMLGroup1_Z_1, oriented by FaceCS1] = sweep_along_normal(RadiatingSurface.face(+z), length=29.132577mm)
  coordinate_system FaceCS2 = face of RadiatingSurface: Origin=(32.5, -12.5, -103.5) FaceID=RadiatingSurface.face(-z) AxisPosn=(-32.5, -12.5, -103.5) WhichAxis=X ZRotationAngle=0deg XOffset=0mm YOffset=0mm FaceNormal(0, 0, -1)
  PML_RadiatingSurface_2 [PMLGroup1_Z_1, oriented by FaceCS2] = sweep_along_normal(RadiatingSurface.face(-z), length=29.132577mm)
  coordinate_system FaceCS3 = face of RadiatingSurface: Origin=(32.5, -12.5, 2.5) FaceID=RadiatingSurface.face(-y) AxisPosn=(-32.5, -12.5, 2.5) WhichAxis=X ZRotationAngle=0deg XOffset=0mm YOffset=0mm FaceNormal(0, -1, 0)
  PML_RadiatingSurface_3 [PMLGroup1_Z_1, oriented by FaceCS3] = sweep_along_normal(RadiatingSurface.face(-y), length=29.132577mm)
  coordinate_system FaceCS4 = face of RadiatingSurface: Origin=(-32.5, -12.5, 2.5) FaceID=RadiatingSurface.face(-x) AxisPosn=(-32.5, 12.5, 2.5) WhichAxis=X ZRotationAngle=0deg XOffset=0mm YOffset=0mm FaceNormal(-1, 0, 0)
  PML_RadiatingSurface_4 [PMLGroup1_Z_1, oriented by FaceCS4] = sweep_along_normal(RadiatingSurface.face(-x), length=29.132577mm)
  coordinate_system FaceCS5 = face of RadiatingSurface: Origin=(-32.5, 12.5, 2.5) FaceID=RadiatingSurface.face(+y) AxisPosn=(32.5, 12.5, 2.5) WhichAxis=X ZRotationAngle=0deg XOffset=0mm YOffset=0mm FaceNormal(0, 1, 0)
  PML_RadiatingSurface_5 [PMLGroup1_Z_1, oriented by FaceCS5] = sweep_along_normal(RadiatingSurface.face(+y), length=29.132577mm)
  coordinate_system FaceCS6 = face of RadiatingSurface: Origin=(32.5, 12.5, -103.5) FaceID=RadiatingSurface.face(+x) AxisPosn=(32.5, 12.5, 2.5) WhichAxis=X ZRotationAngle=0deg XOffset=0mm YOffset=0mm FaceNormal(1, 0, 0)
  PML_RadiatingSurface_6 [PMLGroup1_Z_1, oriented by FaceCS6] = sweep_along_normal(RadiatingSurface.face(+x), length=29.132577mm)
  PML_RadiatingSurface_7 [PMLGroup1_XZ_1, oriented by FaceCS1] = sweep_along_normal(PML_RadiatingSurface_1.face(at (0, -12.5, 17.0663)), length=29.132577mm)
  PML_RadiatingSurface_8 [PMLGroup1_YZ_1, oriented by FaceCS4] = sweep_along_normal(PML_RadiatingSurface_1.face(at (-32.5, 0, 17.0663)), length=29.132577mm)
  PML_RadiatingSurface_9 [PMLGroup1_YZ_1, oriented by FaceCS5] = sweep_along_normal(PML_RadiatingSurface_1.face(at (0, 12.5, 17.0663)), length=29.132577mm)
  PML_RadiatingSurface_10 [PMLGroup1_YZ_1, oriented by FaceCS1] = sweep_along_normal(PML_RadiatingSurface_1.face(at (32.5, 0, 17.0663)), length=29.132577mm)
  PML_RadiatingSurface_11 [PMLGroup1_YZ_1, oriented by FaceCS2] = sweep_along_normal(PML_RadiatingSurface_2.face(at (0, -12.5, -118.066)), length=29.132577mm)
  coordinate_system FaceCS7 = face of RadiatingSurface: Origin=(-32.5, -12.5, -103.5) FaceID=RadiatingSurface.face(-z) AxisPosn=(-32.5, 12.5, -103.5) WhichAxis=X ZRotationAngle=0deg XOffset=0mm YOffset=0mm FaceNormal(0, 0, -1)
  PML_RadiatingSurface_12 [PMLGroup1_YZ_1, oriented by FaceCS7] = sweep_along_normal(PML_RadiatingSurface_2.face(at (-32.5, 0, -118.066)), length=29.132577mm)
  coordinate_system FaceCS8 = face of RadiatingSurface: Origin=(-32.5, 12.5, -103.5) FaceID=RadiatingSurface.face(-z) AxisPosn=(32.5, 12.5, -103.5) WhichAxis=X ZRotationAngle=0deg XOffset=0mm YOffset=0mm FaceNormal(0, 0, -1)
  PML_RadiatingSurface_13 [PMLGroup1_YZ_1, oriented by FaceCS8] = sweep_along_normal(PML_RadiatingSurface_2.face(at (0, 12.5, -118.066)), length=29.132577mm)
  PML_RadiatingSurface_14 [PMLGroup1_XZ_1, oriented by FaceCS2] = sweep_along_normal(PML_RadiatingSurface_2.face(at (32.5, 0, -118.066)), length=29.132577mm)
  PML_RadiatingSurface_15 [PMLGroup1_XZ_1, oriented by FaceCS4] = sweep_along_normal(PML_RadiatingSurface_3.face(at (-32.5, -27.0663, -50.5)), length=29.132577mm)
  PML_RadiatingSurface_16 [PMLGroup1_XZ_1, oriented by FaceCS3] = sweep_along_normal(PML_RadiatingSurface_3.face(at (32.5, -27.0663, -50.5)), length=29.132577mm)
  PML_RadiatingSurface_17 [PMLGroup1_XZ_1, oriented by FaceCS5] = sweep_along_normal(PML_RadiatingSurface_4.face(at (-47.0663, 12.5, -50.5)), length=29.132577mm)
  PML_RadiatingSurface_18 [PMLGroup1_YZ_1, oriented by FaceCS6] = sweep_along_normal(PML_RadiatingSurface_5.face(at (32.5, 27.0663, -50.5)), length=29.132577mm)
  PML_RadiatingSurface_19 [PMLGroup1_XYZ_1, oriented by FaceCS4] = sweep_along_normal(PML_RadiatingSurface_7.face(at (-32.5, -27.0663, 17.0663)), length=29.132577mm)
  PML_RadiatingSurface_20 [PMLGroup1_XYZ_1, oriented by FaceCS1] = sweep_along_normal(PML_RadiatingSurface_7.face(at (32.5, -27.0663, 17.0663)), length=29.132577mm)
  PML_RadiatingSurface_21 [PMLGroup1_XYZ_1, oriented by FaceCS5] = sweep_along_normal(PML_RadiatingSurface_8.face(at (-47.0663, 12.5, 17.0663)), length=29.132577mm)
  coordinate_system FaceCS9 = face of RadiatingSurface: Origin=(32.5, 12.5, 2.5) FaceID=RadiatingSurface.face(+z) AxisPosn=(-32.5, 12.5, 2.5) WhichAxis=X ZRotationAngle=0deg XOffset=0mm YOffset=0mm FaceNormal(0, 0, 1)
  PML_RadiatingSurface_22 [PMLGroup1_XYZ_1, oriented by FaceCS9] = sweep_along_normal(PML_RadiatingSurface_9.face(at (32.5, 27.0663, 17.0663)), length=29.132577mm)
  PML_RadiatingSurface_23 [PMLGroup1_XYZ_1, oriented by FaceCS7] = sweep_along_normal(PML_RadiatingSurface_11.face(at (-32.5, -27.0663, -118.066)), length=29.132577mm)
  PML_RadiatingSurface_24 [PMLGroup1_XYZ_1, oriented by FaceCS2] = sweep_along_normal(PML_RadiatingSurface_11.face(at (32.5, -27.0663, -118.066)), length=29.132577mm)
  PML_RadiatingSurface_25 [PMLGroup1_XYZ_1, oriented by FaceCS8] = sweep_along_normal(PML_RadiatingSurface_12.face(at (-47.0663, 12.5, -118.066)), length=29.132577mm)
  PML_RadiatingSurface_26 [PMLGroup1_XYZ_1, oriented by FaceCS6] = sweep_along_normal(PML_RadiatingSurface_13.face(at (32.5, 27.0663, -118.066)), length=29.132577mm)
  group PMLGroup1 = PML_RadiatingSurface_1..PML_RadiatingSurface_26
boundaries and excitations:
  PEC_Waveguide: Perfect E Objects=[FeedXMinus, FeedXPlus, FeedYMinus, FeedYPlus, HornXMinus, HornXPlus, HornYMinus, HornYPlus]
  PML_radiation1: Radiation Faces=RadiatingSurface.face(+z) IsForPML
  PML_radiation2: Radiation Faces=RadiatingSurface.face(-z) IsForPML
  PML_radiation3: Radiation Faces=RadiatingSurface.face(-y) IsForPML
  PML_radiation4: Radiation Faces=RadiatingSurface.face(-x) IsForPML
  PML_radiation5: Radiation Faces=RadiatingSurface.face(+y) IsForPML
  PML_radiation6: Radiation Faces=RadiatingSurface.face(+x) IsForPML
  WavePort1: Wave Port Objects=WavePortSheet WavePortType=Modal NumModes=12 Modes{Mode1{IntLine{(0, -5, -100) -> (0, 5, -100)} CharImp=Zpi RenormImp=50ohm} Mode2{CharImp=Zpi RenormImp=50ohm} Mode3{CharImp=Zpi RenormImp=50ohm} Mode4{CharImp=Zpi RenormImp=50ohm} Mode5{CharImp=Zpi RenormImp=50ohm} Mode6{CharImp=Zpi RenormImp=50ohm} Mode7{CharImp=Zpi RenormImp=50ohm} Mode8{CharImp=Zpi RenormImp=50ohm} Mode9{CharImp=Zpi RenormImp=50ohm} Mode10{CharImp=Zpi RenormImp=50ohm} Mode11{CharImp=Zpi RenormImp=50ohm} Mode12{CharImp=Zpi RenormImp=50ohm}}
setups:
  Setup30GHz: HfssDriven Frequency=30GHz MaxDeltaS=0.02 MaximumPasses=15 MinimumPasses=3 MinimumConvergedPasses=3 PercentRefinement=30 BasisOrder=1 PortAccuracy=2 DrivenSolverType="Direct Solver"
source amplitudes:
  WavePort1:1: 1W 0deg
  WavePort1:2..WavePort1:12: 0W 0deg
radiation setups:
  3D: Infinite Sphere Theta=0deg..180deg step 2deg Phi=-180deg..180deg step 2deg
  Elevation: Infinite Sphere Theta=-180deg..180deg step 1deg Phi=0deg..90deg step 90deg
  Azimuth: Infinite Sphere Theta=90deg..90deg step 0deg Phi=-180deg..180deg step 1deg
  OpenApertureSphere: Infinite Sphere Theta=0deg..90deg step 0.5deg Phi=0deg..270deg step 90deg
